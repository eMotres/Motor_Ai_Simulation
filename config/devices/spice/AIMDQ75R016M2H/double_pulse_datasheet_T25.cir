* Double-pulse test — AIMDQ75R016M2H (AIMDQ75R016M2H_L1)
* Infineon datasheet Fig. F (dynamic test circuit): DUT = low side,
* second device = high side, freewheeling in its own body diode.
* generated by motor_ai_sim.inverter.spice; model spice:IFX_CoolSiC_Gen2_750V_Auto_obfuscated_wave1_3_4_6_LTSpice.lib@de5aba25b76c:AIMDQ75R016M2H_L1
* V_DD=500 V  I=55.8 A  Tj=25 C  RG,on=1.8 ohm  RG,off=1.8 ohm  V_GS=0/18 V  Lsigma=15 nH  Lg=2 nH  Csigma=20 pF  Lload=8.960573 uH
* ngspice / KiCad: run with 'set ngbehavior=psa' (in .spiceinit) — the
* vendor library is written in PSpice/SIMetrix syntax; the .include is the DDT()-translated copy (models.py).
* LTspice / PSpice / SIMetrix: .include the vendor file itself: IFX_CoolSiC_Gen2_750V_Auto_obfuscated_wave1_3_4_6_LTSpice.lib
.include "../_vendor/_ltspice/AIMDQ75R016M2H.de5aba25b76c.lib"

* DC link and the power loop (Lsigma split half/half, Fig. F)
VDD pbus 0 500
LS1 pbus p1 7.5e-09
LLOAD p1 mid 8.960573e-06
CSIG p1 mid 2e-11
VIDH p1 dh 0
XH dh gh mid kh AIMDQ75R016M2H_L1
VIDL mid dl 0
XL dl gl sl kl AIMDQ75R016M2H_L1
LS2 sl 0 7.5e-09

* high side: held off through its own gate resistor
VGH ghd kh 0
RGH ghd ghi 1.8
LGH ghi gh 2e-09

* DUT gate driver (referenced to the Kelvin source where there is one)
VDRV drv kl PWL(0 0 2e-07 0 2.02e-07 18 1.2e-06 18 1.202e-06 0 1.7e-06 0 1.702e-06 18 2.1e-06 18 2.102e-06 0)
RGL drv gli 1.8
LGL gli gl 2e-09

.save v(dl) v(sl) v(kl) v(gl) v(drv) i(vidl) v(dh) v(mid) v(kh) i(vidh) v(p1)
.temp 25
.options reltol=0.001 abstol=1e-9 vntol=1e-5 itl4=200
* LTspice: keep every time point, write doubles, alt solver
.options plotwinsize=0 numdgt=15 solver=alt
.tran 1e-09 2.3e-06 0 1e-09
.end
