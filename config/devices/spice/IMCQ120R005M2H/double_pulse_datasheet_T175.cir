* Double-pulse test — IMCQ120R005M2H (IMCQ120R005M2H_L1)
* Infineon datasheet Fig. F (dynamic test circuit): DUT = low side,
* second device = high side, freewheeling in its own body diode.
* generated by motor_ai_sim.inverter.spice; model spice:CoolSiC_1200V_Gen2_Trench_MOSFET_L1_L3.lib@f0ce84eb1cf5:IMCQ120R005M2H_L1
* V_DD=800 V  I=138.2 A  Tj=175 C  RG,on=2.3 ohm  RG,off=2.3 ohm  V_GS=0/18 V  Lsigma=15 nH  Lg=2 nH  Csigma=20 pF  Lload=5.788712 uH
* ngspice / KiCad: run with 'set ngbehavior=psa' (in .spiceinit) — the
* vendor library is written in PSpice/SIMetrix syntax; the .include is the DDT()-translated copy (models.py).
* LTspice / PSpice / SIMetrix: .include the vendor file itself: CoolSiC_1200V_Gen2_Trench_MOSFET_L1_L3.lib
.include "../_vendor/_ngspice/CoolSiC_1200V_Gen2_Trench_MOSFET_L1_L3.f0ce84eb1cf5.ngspice.lib"

* DC link and the power loop (Lsigma split half/half, Fig. F)
VDD pbus 0 800
LS1 pbus p1 7.5e-09
LLOAD p1 mid 5.788712e-06
CSIG p1 mid 2e-11
VIDH p1 dh 0
XH dh gh mid kh IMCQ120R005M2H_L1
VIDL mid dl 0
XL dl gl sl kl IMCQ120R005M2H_L1
LS2 sl 0 7.5e-09

* high side: held off through its own gate resistor
VGH ghd kh 0
RGH ghd ghi 2.3
LGH ghi gh 2e-09

* DUT gate driver (referenced to the Kelvin source where there is one)
VDRV drv kl PWL(0 0 2e-07 0 2.02e-07 18 1.179859e-06 18 1.181859e-06 0 1.679859e-06 0 1.681859e-06 18 2.079859e-06 18 2.081859e-06 0)
RGL drv gli 2.3
LGL gli gl 2e-09

.save v(dl) v(sl) v(kl) v(gl) v(drv) i(vidl) v(dh) v(mid) v(kh) i(vidh) v(p1)
.temp 175
.options reltol=0.001 abstol=1e-9 vntol=1e-5 itl4=200
.tran 1e-09 2.279859e-06 0 1e-09
.end
