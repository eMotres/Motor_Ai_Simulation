* Double-pulse test — IQE050N08NM5SC (IQE050N08NM5SC)
* Infineon datasheet Fig. F (dynamic test circuit): DUT = low side,
* second device = high side, freewheeling in its own body diode.
* generated by motor_ai_sim.inverter.spice; model spice:OptiMOS5_80V_Spice.lib@fc2b9524e8b0:IQE050N08NM5SC
* V_DD=40 V  I=20 A  Tj=25 C  RG,on=1.6 ohm  RG,off=1.6 ohm  V_GS=0/10 V  Lsigma=2 nH  Lg=1 nH  Csigma=5 pF  Lload=1 uH
* ngspice / KiCad: run with 'set ngbehavior=psa' (in .spiceinit) — the
* vendor library is written in PSpice/SIMetrix syntax.
* LTspice / PSpice / SIMetrix: .include the vendor file itself: OptiMOS5_80V_Spice.lib
.include "../_vendor/infineon-optimos-powermosfet-pspice-80v-n-channel-simulationmodels-en/OptiMOS5/OptiMOS5_80V_Spice.lib"

* DC link and the power loop (Lsigma split half/half, Fig. F)
VDD pbus 0 40
LS1 pbus p1 1e-09
LLOAD p1 mid 1e-06
CSIG p1 mid 5e-12
VIDH p1 dh 0
XH dh gh mid thh0 thh1 thh2 IQE050N08NM5SC
VTH1 thh1 0 25
VTH2 thh2 0 25
VIDL mid dl 0
XL dl gl sl thl0 thl1 thl2 IQE050N08NM5SC
VTL1 thl1 0 25
VTL2 thl2 0 25
LS2 sl 0 1e-09

* high side: held off through its own gate resistor
VGH ghd mid 0
RGH ghd ghi 1.6
LGH ghi gh 1e-09

* DUT gate driver (referenced to the Kelvin source where there is one)
VDRV drv sl PWL(0 0 1e-07 0 1.01e-07 10 6e-07 10 6.01e-07 0 9e-07 0 9.01e-07 10 1.2e-06 10 1.201e-06 0)
RGL drv gli 1.6
LGL gli gl 1e-09

.temp 25
.options reltol=0.001 abstol=1e-9 vntol=1e-5 itl4=200
.tran 2e-10 1.4e-06 0 2e-10
.end
